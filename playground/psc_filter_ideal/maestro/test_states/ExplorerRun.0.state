ADE simulation setup
Test playground_psc_filter_1: playground/psc_filter_ideal/schematic, simulator spectre
  Models: /scratch/cs199-byl/ucb-tvip/tvip-analog-workspace/libs/sky130_fd_pr_main/../../models/sky130.lib.spice[tt]
  Variables: R = 1
  Temperature: 27
  Analysis pss: engine=Shooting fund=1.25G harms=19
  Analysis pac: start=100k stop=1G fund=1.25G
  Output VT("/VIN") (unticked)
  Output v (/VOUTp /VOUTm); pac dB20(V) = db((vh('pac "/VOUTp") - vh('pac "/VOUTm")))

ADE simulation setup
Run mode: Single Run, Sweeps and Corners
Tests:
  playground_psc_filter_1: playground/psc_filter_ideal/schematic, simulator spectre
    Variables: R = {Inclusion List}100K{Inclusion List}{From/To}Auto:1:20:100K{From/To}
    Outputs: nil; VT("/VIN"); (VT); (VT("/VOUT+") (- VT("/VOUT-"))); VT("/VOUT+")

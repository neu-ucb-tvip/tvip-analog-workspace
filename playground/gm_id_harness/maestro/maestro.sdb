ADE simulation setup
Run mode: Single Run, Sweeps and Corners
Tests:
  playground_gm_id_harness_1: playground/gm_id_harness/schematic, simulator spectre
    Variables: LN = 600n; LP = 300n; MN = 1; MP = 1; VBN = 1; VBP = 1; VDN = 600m; VDP = 600m; VGN = 900m; VGP = 600m; VSN = 400m; VSP = 1.4; WN = 30u; WP = 12u
    Outputs: gmN; idN; r0N; vovN

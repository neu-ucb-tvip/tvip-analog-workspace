ADE simulation setup
Test playground_gm_id_harness_1: playground/gm_id_harness/schematic, simulator spectre
  Models: /scratch/cs199-byl/ucb-tvip/tvip-analog-workspace/libs/sky130_fd_pr_main/../../models/sky130.lib.spice[tt]
  Variables: LN = 600n; LP = 300n; MN = 1; MP = 1; VBN = 1; VBP = 1; VDN = 600m; VDP = 600m; VGN = 900m; VGP = 600m; VSN = 400m; VSP = 1.4; WN = 30u; WP = 12u
  Temperature: 27
  Analysis dc: (saves the operating point)
  Output gmN = OP("NM0.msky130_fd_pr__nfet_01v8" "gm")
  Output idN = OP("NM0.msky130_fd_pr__nfet_01v8" "id")
  Output r0N = OP("NM0.msky130_fd_pr__nfet_01v8" "rout")
  Output vovN = ((2 * idN) / gmN)
Run mode: Single Run, Sweeps and Corners

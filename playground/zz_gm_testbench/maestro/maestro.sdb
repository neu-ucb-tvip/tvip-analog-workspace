ADE simulation setup
Run mode: Single Run, Sweeps and Corners
Tests:
  playground_zz_gm_testbench_1: playground/zz_gm_testbench/schematic, simulator spectre

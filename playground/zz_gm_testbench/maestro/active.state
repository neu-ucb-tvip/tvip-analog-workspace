ADE simulation setup
Test playground_zz_gm_testbench_1: playground/zz_gm_testbench/schematic, simulator spectre
  Models: /scratch/cs199-byl/ucb-tvip/tvip-analog-workspace/libs/sky130_fd_pr_main/../../models/sky130.lib.spice[tt]
  Temperature: 27
  Analysis ac: start=1 stop=1T
Run mode: Single Run, Sweeps and Corners

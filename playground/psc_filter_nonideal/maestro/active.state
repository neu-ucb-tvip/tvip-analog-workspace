ADE simulation setup
Test playground_psc_filter_nonideal_1: playground/psc_filter_nonideal/schematic, simulator spectre
  Models: /scratch/cs199-byl/ucb-tvip/tvip-analog-workspace/libs/sky130_fd_pr_main/../../models/sky130.lib.spice[tt]
  Temperature: 27
  Analysis pac: start=1 stop=1G fund=1.25G
  Analysis pss: engine=Shooting fund=1.25G harms=19
Run mode: Single Run, Sweeps and Corners

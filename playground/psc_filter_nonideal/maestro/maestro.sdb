ADE simulation setup
Run mode: Single Run, Sweeps and Corners
Tests:
  playground_psc_filter_nonideal_1: playground/psc_filter_nonideal/schematic, simulator spectre

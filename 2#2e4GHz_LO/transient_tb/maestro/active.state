ADE simulation setup
Test 2.4GHz_LO_main_tb_1: 2.4GHz_LO/transient_tb/schematic, simulator spectre
  Models: /home/aa/users/cs199-cdv/tvip-analog-workspace/libs/sky130_fd_pr_main/../../models/sky130.lib.spice[tt]
  Variables: lenp = 600n; widp = 90u; R = 549.7; i = .4m; len = 600n; wid = 90u; C = .27p; L = 1.52n; Q = 12; delF = 10k
  Temperature: 27
  Analysis tran: stop=100n errpreset=conservative noisefmax=100G noisefmin=1 noisescale=1
  Analysis pss: engine=Shooting fund=4.8G harms=20 oscana=t p=/vo+ n=/vo- errpreset=conservative
  Analysis pnoise: start=10k stop=1M fund=4.8G p=/vo+ n=/vo- sweeptype=relative relharmnum=1 noisetype=timeaverage
  Output vo+ = VT("/vo+")
  Output vo- = VT("/vo-")
  Output virtual gnd = vtime('tran "/I0/net1") (unticked)
  Output vout = (vtime('tran "/vo+") - vtime('tran "/vo-")) (unticked)
  Output dft = dB20(dft(vout 5e-08 1e-07 4096 "Rectangular" 0 0 1))
  Output vo-_i = itime('tran "/I7/IPRB1/MINUS") (unticked)
  Output vo+_i = itime('tran "/I7/IPRB0/MINUS") (unticked)
  Output fo = xmax(peak(dB20(dft(vout 5e-08 1e-07 4096 "Rectangular" 0 0 1)) ?from 1000000000 ?to 2e+10 ?xtol 0 ?ytol 0 ?withLast nil) 1) (unticked)
  Output Phase Noise; dBc/Hz, Relative Harmonic = 1 = pn('pnoise) (unticked)
  Output Phase noise FOM = ((value(pn('pnoise) VAR("delF")) + (10 * log((VAR("i") * 1.8)))) - ((20 * log(fo)) / VAR("delF"))) (unticked)
  Output vout_swing = (ymax(vout) - ymin(vout))
  Output clipped_vout = clip(vout 3e-08 1e-07) (unticked)
  Signals: /vo+, /vo-
Run mode: Single Run, Sweeps and Corners

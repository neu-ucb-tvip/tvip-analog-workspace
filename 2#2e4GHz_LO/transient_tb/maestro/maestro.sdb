ADE simulation setup
Run mode: Single Run, Sweeps and Corners
Tests:
  2.4GHz_LO_main_tb_1: 2.4GHz_LO/transient_tb/schematic, simulator spectre
    Variables: C = .27p; L = 1.52n; Q = 12; len = 600n; wid = 90u; i = .4m; R = 549.7; lenp = 600n; widp = 90u; delF = 10k
    Outputs: vo+; vo-; dft(vout 10 1e+10 64 "Blackman" 1 "default" 1.0); dft(vout 0 1e+10 64 "Blackman" 1 "default" 1.0); dft; fo; ((value(pn('pnoise) VAR("delF")) - ((20 * log(xmax(peak(dB20(dft(vout 5e-08 1e-07 4096 "Rectangular" 0 0 1)) ?from 1000000000 ?to 2e+10 ?xtol 0 ?ytol 0 ?withLast nil) 1))) / VAR("delF")))); ((value(pn('pnoise) VAR("delF")))); (- ((20 * log(xmax(peak(dB20(dft(vout 5e-08 1e-07 4096 "Rectangular" 0 0 1)) ?from 1000000000 ?to 2e+10 ?xtol 0 ?ytol 0 ?withLast nil) 1))) / VAR("delF"))); value(pn('pnoise) VAR("delF")); VAR("delF"); (20 * (log)); (value(pn('pnoise) VAR("delF")) + (10 * log((VAR("i") * 1.8)))); Phase noise FOM; vout_swing; clipped_vout

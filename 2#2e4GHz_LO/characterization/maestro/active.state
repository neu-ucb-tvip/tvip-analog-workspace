ADE simulation setup
Test 2.4GHz_LO_characterization_1: 2.4GHz_LO/characterization/schematic, simulator spectre
  Models: /home/aa/users/cs199-cdv/tvip-analog-workspace/libs/sky130_fd_pr_main/../../models/sky130.lib.spice[tt]
  Variables: vds = 1.8; vgs = .7
  Temperature: 27
  Analysis sp: start=10000k stop=10000G ports=("/PORT0" "/PORT1")
  Analysis ac: start=100k stop=1000G
  Analysis dc: (saves the operating point)
  Output i /NM0/D; dc (I) = (- IDC("/IPRB0/MINUS"))
  Output dc
  Output i /IPRB0/MINUS; ac mag(I) = ifreq('ac "/IPRB0/MINUS")
  Output i /IPRB0/MINUS; ac dB20(I) = db(ifreq('ac "/IPRB0/MINUS"))
  Output Gmax dB10 = db10(gmax(sp(1 1 ?result "sp") sp(1 2 ?result "sp") sp(2 1 ?result "sp") sp(2 2 ?result "sp")))
Run mode: Single Run, Sweeps and Corners

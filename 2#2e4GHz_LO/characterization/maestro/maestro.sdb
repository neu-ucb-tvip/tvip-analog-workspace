ADE simulation setup
Run mode: Single Run, Sweeps and Corners
Tests:
  2.4GHz_LO_characterization_1: 2.4GHz_LO/characterization/schematic, simulator spectre
    Variables: vds = 1.8; vgs = .7
    Outputs: i /NM0/D; dc (I); dc

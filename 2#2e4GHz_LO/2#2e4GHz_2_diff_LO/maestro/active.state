ADE simulation setup
Test 2.4GHz_LO_main_tb_1: 2.4GHz_LO/2.4GHz_2_diff_LO/schematic, simulator spectre
  Models: /home/aa/users/cs199-cdv/tvip-analog-workspace/libs/sky130_fd_pr_main/../../models/sky130.lib.spice[tt]
  Variables: lenp = 150n; widp = 45u; i = .4m; len = 150n; wid = 45u; C = .59p; L = 1.52n; Q = 12
  Temperature: 27
  Analysis dc: (saves the operating point)
  Analysis tran: stop=100n errpreset=conservative
  Output vo+ = VT("/vo+")
  Output vo- = VT("/vo-")
  Output virtual gnd = vtime('tran "/I0/net1") (unticked)
  Output vout = (vtime('tran "/vo+") - vtime('tran "/vo-")) (unticked)
  Output dft = dB20(dft(vout 5e-08 1e-07 4096 "Rectangular" 0 0 1))
  Output frequency(vout)
  Output v1 = vtime('tran "/v1")
  Output v2 = vtime('tran "/v2")
  Output v3 = vtime('tran "/v3")
  Output v4 = vtime('tran "/v4")
  Signals: /vo+, /vo-
Run mode: Single Run, Sweeps and Corners

ADE simulation setup
Run mode: Single Run, Sweeps and Corners
Tests:
  2.4GHz_LO_main_tb_1: 2.4GHz_LO/2.4GHz_2_diff_LO/schematic, simulator spectre
    Variables: C = .59p; L = 1.52n; Q = 12; len = 150n; wid = 45u; i = .4m; lenp = 150n; widp = 45u
    Outputs: vo+; vo-; dft(vout 10 1e+10 64 "Blackman" 1 "default" 1.0); dft(vout 0 1e+10 64 "Blackman" 1 "default" 1.0); dft; frequency(vout)

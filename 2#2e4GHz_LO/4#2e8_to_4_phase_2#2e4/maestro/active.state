ADE simulation setup
Test 2.4GHz_LO_4.8_to_4_phase_2.4_2: 2.4GHz_LO/4.8_to_4_phase_2.4/schematic, simulator spectre
  Models: /home/aa/users/cs199-cdv/tvip-analog-workspace/libs/sky130_fd_pr_main/../../models/sky130.lib.spice[tt]
  Variables: r = 3.824; nwid = 5u; crossw = 10u; invw = 5u; tw = 4u; C = .72p; i = .8m; L = 1.52n; wid = 5u; widp = 9u
  Temperature: 27
Test PSS: 2.4GHz_LO/4.8_to_4_phase_2.4/schematic, simulator spectre
  Models: /home/aa/users/cs199-cdv/tvip-analog-workspace/libs/sky130_fd_pr_main/../../models/sky130.lib.spice[tt]
  Variables: mixwid = 4u; r = 3.824; nwid = 5u; crossw = 10u; invw = 5u; tw = 4u; C = .72p; i = .8m; L = 1.52n; wid = 5u; widp = 9u
  Temperature: 27
Test 2.4GHz_LO_4.8_to_4_phase_2.4_1: 2.4GHz_LO/4.8_to_4_phase_2.4/schematic, simulator spectre
  Models: /home/aa/users/cs199-cdv/tvip-analog-workspace/libs/sky130_fd_pr_main/../../models/sky130.lib.spice[tt]
  Variables: mixwid = 4u; r = 3.824; nwid = 2u; crossw = 2u; tw = 1u; C = .55p; i = .42m; L = 1.52n
  Temperature: 27
  Analysis tran: stop=50n errpreset=conservative noisefmax=100G noisefmin=1 noisescale=1
  Analysis dc: (saves the operating point)
  Output 4.8Ghz spectrum = dB20(dft(clip(osc_out_plus 3e-08 5e-08) 3e-08 5e-08 1024 "Rectangular" 1 "default" 1.0)) (unticked)
  Output clk_0 = vtime('tran "/clk_0")
  Output v /clk_180; tran (V) = vtime('tran "/clk_180")
  Output v /clk270; tran (V) = vtime('tran "/clk270")
  Output v /clk_90; tran (V) = vtime('tran "/clk_90")
  Output fast_minus = vtime('tran "/fast_minus")
  Output 2.4Ghz spectrum = dB20(dft(clip(clk_0 2e-08 3e-08) 7.5e-08 1e-07 1024 "Rectangular" 1 "default" 1.0)) (unticked)
  Output total_i = itime('tran "/IPRB0/PLUS") (unticked)
  Output integrated curr = (integ(total_i 3e-08 4e-08 nil) / 1e-08)
  Output vco_out_spectrum = dB20(dft(clip(osc_out_plus 3e-08 5e-08) 3e-08 5e-08 1024 "Rectangular" 1 "default" 1.0)) (unticked)
  Output osc_out_plus = vtime('tran "/osc_out+") (unticked)
  Output osc_out_minus = vtime('tran "/osc_out-") (unticked)
  Output phase0 = vtime('tran "/phase_0")
  Output phase90 = vtime('tran "/phase_90")
  Output phase180 = vtime('tran "/phase180")
  Output phase270 = vtime('tran "/phase_270")
  Output fast_plus = vtime("tran" "/fast_plus")
  Output inv_osc_plus = ((- osc_out_plus) + 1.54) (unticked)
Test current_power: 2.4GHz_LO/4.8_to_4_phase_2.4/schematic, simulator spectre
  Models: /home/aa/users/cs199-cdv/tvip-analog-workspace/libs/sky130_fd_pr_main/../../models/sky130.lib.spice[tt]
  Variables: mixwid = 4u; r = 3.824; nwid = 2u; crossw = 2u; tw = 1u; C = .72p; i = .42m; L = 1.52n; wid = 5u; widp = 9u
  Temperature: 27
  Analysis tran: stop=50n errpreset=conservative noisefmax=100G noisefmin=1 noisescale=1
  Output total_i = itime('tran "/IPRB0/PLUS")
  Output 4.8_square_i = itime('tran "/IPRB2/PLUS")
  Output ring_i = itime('tran "/IPRB1/PLUS")
  Output nand_i = itime('tran "/IPRB4/PLUS")
  Output integ_total_i = (integ(total_i 3e-08 4e-08 nil) / 1e-08)
  Output LO_i = itime('tran "/IPRB3/PLUS")

ADE simulation setup
Run mode: Single Run, Sweeps and Corners
Tests:
  2.4GHz_LO_4.8_to_4_phase_2.4_1: 2.4GHz_LO/4.8_to_4_phase_2.4/schematic, simulator spectre
    Variables: C = .55p; i = .42m; L = 1.52n; tw = 1u; crossw = 2u; nwid = 2u; r = 3.824; mixwid = 4u
    Outputs: dft(clip(vout 7.5e-08 1e-07) 7.5e-08 1e-07 256 "Rectangular" 1 "default" 1.0); dB20((dft(clip(vout 7.5e-08 1e-07) 7.5e-08 1e-07 256 "Rectangular" 1 "default" 1.0))); dB20(dft(clip(vout 7.5e-08 1e-07) 7.5e-08 1e-07 256 "Rectangular" 1 "default" 1.0)); 4.8Ghz spectrum; dB20(dft((clip (I + 7.5e-08) 1e-07) 7.5e-08 1e-07 1024 "Rectangular" 1 "default" 1.0)); dB20(dft((clip (I_plus 7.5e-08) 1e-07) 7.5e-08 1e-07 1024 "Rectangular" 1 "default" 1.0)); dB20(dft(((clip I_plus 7.5e-08) 1e-07) 7.5e-08 1e-07 1024 "Rectangular" 1 "default" 1.0)); dB20((dft (((clip I_plus 7.5e-08) 1e-07) 7.5e-08 1e-07 1024 "Rectangular" 1 "default" 1.0))); 2.4Ghz spectrum; integral; i; integ(current 3); 0; (integ(current 9e-08 1e-07 nil) / 1e-08); (integ(current 4e-08 5e-08 nil) / 1e-08); vco_out_spectrum; (integ(current 2e-08 3e-08 nil) / 1e-08); (integ(current 2e-08 3e-08 nil)); integ(current 2e-08 3e-08 nil); integ(current 2e-08 2.7e-08 nil); (integ(current 2e-08 2.7e-08 nil) / 2.7e-09); integrated curr; fast_plus; total_i; inv_osc_plus
  PSS (off): 2.4GHz_LO/4.8_to_4_phase_2.4/schematic, simulator spectre
    Variables: r = 3.824; nwid = 5u; crossw = 10u; invw = 5u; tw = 4u; C = .72p; i = .8m; L = 1.52n; wid = 5u; widp = 9u; mixwid = 4u
  current_power: 2.4GHz_LO/4.8_to_4_phase_2.4/schematic, simulator spectre
    Variables: r = 3.824; nwid = 2u; crossw = 2u; tw = 1u; C = .72p; i = .42m; L = 1.52n; wid = 5u; widp = 9u; mixwid = 4u
    Outputs: integ_total_i; total_i
Device parameters:
  2.4GHz_LO/4.8_to_4_phase_2.4/schematic/NM1.fingers = 4
  2.4GHz_LO/4.8_to_4_phase_2.4/schematic/PM47.fingers = 4
  2.4GHz_LO/4.8_to_4_phase_2.4/schematic/PM47.w = 10u
  2.4GHz_LO/4.8_to_4_phase_2.4/schematic/NM54.fw = 2.5u
  2.4GHz_LO/4.8_to_4_phase_2.4/schematic/NM56.fw = 2u
  2.4GHz_LO/4.8_to_4_phase_2.4/schematic/PM49.fw = 1u
  2.4GHz_LO/4.8_to_4_phase_2.4/schematic/PM49.w = 4u

ADE simulation setup
Test current_power: 2.4GHz_LO/4.8_to_4_phase_2.4/schematic, simulator spectre
  Models: /home/aa/users/cs199-cdv/tvip-analog-workspace/libs/sky130_fd_pr_main/../../models/sky130.lib.spice[tt]
  Variables: mixwid = 4u; r = 3.824; nwid = 2u; crossw = 2u; tw = 1u; C = .72p; i = .42m; L = 1.52n; wid = 5u; widp = 9u
  Temperature: 27
  Analysis tran: stop=50n errpreset=conservative noisefmax=100G noisefmin=1 noisescale=1
  Output total_i = itime('tran "/IPRB0/PLUS")
  Output 4.8_square_i = itime('tran "/IPRB2/PLUS")
  Output ring_i = itime('tran "/IPRB1/PLUS")
  Output nand_i = itime('tran "/IPRB4/PLUS")
  Output integ_total_i = (integ(total_i 3e-08 4e-08 nil) / 1e-08)
  Output LO_i = itime('tran "/IPRB3/PLUS")

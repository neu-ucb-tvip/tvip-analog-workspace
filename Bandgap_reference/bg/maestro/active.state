ADE simulation setup
Test 123_bg_1: Bandgap_reference/bg/schematic, simulator spectre
  Models: /home/cc/ee140/sp25/class/ee140-aab/cadence/sky130_release_0.0.4/libs/sky130_fd_pr_main/../../models/sky130.lib.spice[tt]
  Temperature: 26
  Analysis dc: sweep temperature start=-25 stop=140 (saves the operating point)
Run mode: Single Run, Sweeps and Corners

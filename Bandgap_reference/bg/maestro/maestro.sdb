ADE simulation setup
Run mode: Single Run, Sweeps and Corners
Tests:
  123_bg_1: Bandgap_reference/bg/schematic, simulator spectre

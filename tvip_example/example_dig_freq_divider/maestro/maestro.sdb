ADE simulation setup
Run mode: Single Run, Sweeps and Corners
Tests:
  tvip_example_example_dig_counter_stdcells_1: tvip_example/example_dig_freq_divider/schematic, simulator spectre
    Variables: CLK_FREQ = 10M

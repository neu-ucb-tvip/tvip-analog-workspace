ADE simulation setup
Test tvip_example_example_dig_counter_stdcells_1: tvip_example/example_dig_freq_divider/schematic, simulator spectre
  Models: /bwrcq/C/dlovell98/sky130/tvip-analog-workspace/libs/sky130_fd_pr_main/../../models/sky130.lib.spice[tt]
  Variables: CLK_FREQ = 10M
  Temperature: 27
  Analysis tran: stop=50u errpreset=conservative
  Output v /clk; tran (V) = vtime('tran "/clk")
  Output v /clk_div_2; tran (V) = vtime('tran "/clk_div_2")
  Output v /clk_div_4; tran (V) = vtime('tran "/clk_div_4")
Run mode: Single Run, Sweeps and Corners

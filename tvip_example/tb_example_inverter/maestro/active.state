ADE simulation setup
Test tvip_example_tb_example_inverter_1: tvip_example/tb_example_inverter/schematic, simulator spectre
  Models: /bwrcq/C/dlovell98/sky130/tvip-analog-workspace/libs/sky130_fd_pr_main/../../models/sky130.lib.spice[tt]
  Variables: vsin_ac_mag = 1; vsin_dc = 0.9; vsin_freq = 1M; vsin_tran_amp = 1.8; vsin_tran_off = 0.9
  Temperature: 27
  Analysis dc: (saves the operating point)
  Analysis ac: start=1k stop=1G
  Analysis tran: stop=1u
  Output v /in; tran (V) = vtime('tran "/in")
  Output v /out; tran (V) = vtime('tran "/out")
  Output v /out; dc (V) = v("/out" ?result nil)
  Output v /out; ac dB20(V) = db(vfreq('ac "/out"))
Run mode: Single Run, Sweeps and Corners

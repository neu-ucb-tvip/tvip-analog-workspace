ADE simulation setup
Run mode: Single Run, Sweeps and Corners
Tests:
  tvip_example_tb_example_inverter_1: tvip_example/tb_example_inverter/schematic, simulator spectre
    Variables: vsin_ac_mag = 1; vsin_dc = 0.9; vsin_freq = 1M; vsin_tran_amp = 1.8; vsin_tran_off = 0.9

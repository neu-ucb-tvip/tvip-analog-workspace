simulator lang=spice

.lib "sky130_release_0.0.4/models/sky130.lib.spice" tt

.include "bg_replace2.post.sp"

VDD (VDD 0) dc 3.3
VSS (GND 0) dc 0
VEn  (En  0) dc 2.0

RL (VBG 0) resistor r=100k

Xbg (VBG En VDD GND) bg_replace2

.dc TEMP -40 125 5

.print DC V(VBG)

ADE simulation setup
Run mode: Single Run, Sweeps and Corners
Tests:
  ring_osc_tb_gm_id_1: ring_osc/tb_gm_id/schematic, simulator spectre
    Variables: L = 300n; nVD = 0; nVG = 100m; nVS = 100m; pVD = 0; pVG = 0; pVS = 0; W = 4u

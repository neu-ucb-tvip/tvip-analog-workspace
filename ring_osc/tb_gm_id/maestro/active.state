ADE simulation setup
Test ring_osc_tb_gm_id_1: ring_osc/tb_gm_id/schematic, simulator spectre
  Models: /home/aa/users/cs199-anb/Desktop/tvip-analog-workspace/libs/sky130_fd_pr_main/../../models/sky130.lib.spice[tt]
  Variables: L = 300n; nVD = 0; nVG = 100m; nVS = 100m; pVD = 0; pVG = 0; pVS = 0; W = 4u
  Temperature: 27
Run mode: Single Run, Sweeps and Corners

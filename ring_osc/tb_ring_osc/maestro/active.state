ADE simulation setup
Test ring_osc_tb_ring_osc_1: ring_osc/tb_ring_osc/schematic, simulator spectre
  Models: /home/aa/users/cs199-anb/Desktop/tvip-analog-workspace/libs/sky130_fd_pr_main/../../models/sky130.lib.spice[tt]
  Variables: VDDA = 1.77
  Temperature: 70
  Initial conditions: /net3 = 0
  Node sets: /net3 = 0
  Analysis ac: start=1 stop=1G
  Analysis dc: (saves the operating point)
  Analysis tran: stop=100n errpreset=conservative
  Output tran_VOUT = VT("/VOUT")
  Output tail_IT = IT("/I7/NM0/D") (unticked)
  Output buffer1_IDC = IDC("/I0/NM5/D") (unticked)
  Output inv1 = VT("/I0/I5/VOUT") (unticked)
  Output inv2 = VT("/I0/I6/VOUT") (unticked)
  Output inv3 = VT("/I0/I7/VOUT") (unticked)
  Output inv4 = VT("/I0/I8/VOUT") (unticked)
  Output period = cross(VT("/I0/VOUT") (0.9) 1 "rising" nil nil nil) (unticked)
  Output average_tail = average(IT("/I7/NM0/D")) (unticked)
  Signals: /net1, /I7/NM0/D (terminal)
Run mode: Single Run, Sweeps and Corners
Setup values for test ring_osc_tb_ring_osc_1: VDDA = 1.77,1.8,1.83

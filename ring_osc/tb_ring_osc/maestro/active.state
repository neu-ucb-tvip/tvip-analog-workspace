ADE simulation setup
Test ring_osc_tb_ring_osc_1: ring_osc/tb_ring_osc/schematic, simulator spectre
  Models: /home/aa/users/cs199-anb/Desktop/tvip-analog-workspace/libs/sky130_fd_pr_main/../../models/sky130.lib.spice[tt]
  Variables: VDDA = 1.77,1.8,1.83
  Temperature: 27
  Analysis tran: stop=100n errpreset=conservative
  Analysis dc: (saves the operating point)
  Output tran_VOUT = VT("/VOUT")
  Output tail_IT = IT("/I7/NM0/D") (unticked)
  Output buffer1_IDC = IDC("/I0/NM5/D") (unticked)
  Output inv1 = VT("/I0/I5/VOUT") (unticked)
  Output inv2 = VT("/I0/I6/VOUT") (unticked)
  Output inv3 = VT("/I0/I7/VOUT") (unticked)
  Output inv4 = VT("/I0/I8/VOUT") (unticked)
  Output period = cross(VT("/I0/VOUT") (0.9) 1 "rising" nil nil nil) (unticked)
  Output average_tail = average(IT("/I7/NM0/D")) (unticked)
  Output bias_10u = IDC("/I9/NM13/D") (unticked)
  Output mirr_curr = IDC("/I9/NM0/D") (unticked)
  Output temp = VT("/I9/VOSC") (unticked)
  Signals: /I9/NM13/D (terminal), /I9/VOSC, /I9/R0/PLUS (terminal), /I9/PM7/S (terminal), /I9/NM0/D (terminal)
Run mode: Single Run, Sweeps and Corners

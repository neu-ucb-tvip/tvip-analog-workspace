ADE simulation setup
Run mode: Single Run, Sweeps and Corners
Tests:
  ring_osc_tb_ring_osc_1: ring_osc/tb_ring_osc/schematic, simulator spectre
    Variables: VDDA = 1.77,1.8,1.83
    Outputs: tail_IT; inv1; inv2; inv3; inv4; tran_VOUT; buffer1_IDC; period; average_tail; bias_10u; mirr_curr; temp

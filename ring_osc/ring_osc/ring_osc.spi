* +++++++++++++++++++++++++++++++++++++++++++++++++++++++++ *
* CDL Netlist:                                              *
*                                                           *
* Cell Name  : ring_osc                                     *
* Netlisted  : Sun Aug 10 18:51:35 2025                     *
* PVS Version: 23.11-s036 Wed Jan 17 18:11:41 PST 2024      *
* +++++++++++++++++++++++++++++++++++++++++++++++++++++++++ *
*.LDD
*.DEVTMPLT 0 R(res_generic_m1) met1_res met1(P) met1(N)
*.DEVTMPLT 1 R(res_generic_m2) met2_res met2(P) met2(N)
*.DEVTMPLT 2 R(res_generic_m3) met3_res met3(P) met3(N)
*.DEVTMPLT 3 R(res_generic_m4) met4_res met4(P) met4(N)
*.DEVTMPLT 4 R(res_generic_m5) met5_res met5(P) met5(N)
*.DEVTMPLT 5 R(RES_GENERIC_ND) diff_res np_term(P) np_term(N)
*.DEVTMPLT 6 R(RES_GENERIC_PD) diff_res pp_term(P) pp_term(N)
*.DEVTMPLT 7 MN(nfet_01v8) nfet_01v8_rec nSourceDrain(D) nfet(G) nSourceDrain(S) pwell(B)
*.DEVTMPLT 8 MP(pfet_01v8) pfet_01v8_rec pSourceDrain(D) pfet(G) pSourceDrain(S) nwell(B)
*.DEVTMPLT 9 R(res_xhigh_po_0p35) res_xhigh_po_0p35_rec prec_resistor_term(P) prec_resistor_term(N) pwell(B)
*.DEVTMPLT 10 C(cap_mim_m3__base) capacitor top_plate(PLUS) bottom_plate(MINUS)

* +++++++++++++++++++++++++++++++++++++++++++++++++++++++++ *
* Sub cell: nfet_01v8_CDNS_754877090682                     *
* +++++++++++++++++++++++++++++++++++++++++++++++++++++++++ *
.subckt nfet_01v8_CDNS_754877090682 1 2 3
** N=30 EP=3 FDC=4
M0 2 3 1 1 nfet_01v8 L=3e-07 W=1.55e-06 $X=0 $Y=0 $dt=7
M1 1 3 2 1 nfet_01v8 L=3e-07 W=1.55e-06 $X=580 $Y=0 $dt=7
M2 2 3 1 1 nfet_01v8 L=3e-07 W=1.55e-06 $X=1160 $Y=0 $dt=7
M3 1 3 2 1 nfet_01v8 L=3e-07 W=1.55e-06 $X=1740 $Y=0 $dt=7
.ends nfet_01v8_CDNS_754877090682

* +++++++++++++++++++++++++++++++++++++++++++++++++++++++++ *
* Sub cell: pfet_01v8_CDNS_754877090683                     *
* +++++++++++++++++++++++++++++++++++++++++++++++++++++++++ *
.subckt pfet_01v8_CDNS_754877090683 1 2 3
** N=100 EP=3 FDC=4
M0 2 3 1 1 pfet_01v8 L=3e-07 W=6.2e-06 $X=0 $Y=0 $dt=8
M1 1 3 2 1 pfet_01v8 L=3e-07 W=6.2e-06 $X=580 $Y=0 $dt=8
M2 2 3 1 1 pfet_01v8 L=3e-07 W=6.2e-06 $X=1160 $Y=0 $dt=8
M3 1 3 2 1 pfet_01v8 L=3e-07 W=6.2e-06 $X=1740 $Y=0 $dt=8
.ends pfet_01v8_CDNS_754877090683

* +++++++++++++++++++++++++++++++++++++++++++++++++++++++++ *
* Sub cell: inverter_nmos4finger_6_2u                       *
* +++++++++++++++++++++++++++++++++++++++++++++++++++++++++ *
.subckt inverter_nmos4finger_6_2u 1 2 3 4
** N=4 EP=4 FDC=8
X111 3 1 2 nfet_01v8_CDNS_754877090682 $T=885 2230 1 0 $X=480 $Y=-100
X112 4 1 2 pfet_01v8_CDNS_754877090683 $T=885 3075 0 0 $X=440 $Y=2895
.ends inverter_nmos4finger_6_2u

* +++++++++++++++++++++++++++++++++++++++++++++++++++++++++ *
* Sub cell: nfet_01v8_CDNS_754877090684                     *
* +++++++++++++++++++++++++++++++++++++++++++++++++++++++++ *
.subckt nfet_01v8_CDNS_754877090684 2 6 7
** N=24 EP=3 FDC=4
M0 2 6 4 7 nfet_01v8 L=3e-07 W=7.5e-07 $X=0 $Y=0 $dt=7
M1 3 6 2 7 nfet_01v8 L=3e-07 W=7.5e-07 $X=580 $Y=0 $dt=7
M2 2 6 3 7 nfet_01v8 L=3e-07 W=7.5e-07 $X=1160 $Y=0 $dt=7
M3 1 6 2 7 nfet_01v8 L=3e-07 W=7.5e-07 $X=1740 $Y=0 $dt=7
.ends nfet_01v8_CDNS_754877090684

* +++++++++++++++++++++++++++++++++++++++++++++++++++++++++ *
* Sub cell: pfet_01v8_CDNS_754877090685                     *
* +++++++++++++++++++++++++++++++++++++++++++++++++++++++++ *
.subckt pfet_01v8_CDNS_754877090685 2 3
** N=50 EP=2 FDC=4
M0 2 3 1 1 pfet_01v8 L=3e-07 W=3e-06 $X=0 $Y=0 $dt=8
M1 1 3 2 1 pfet_01v8 L=3e-07 W=3e-06 $X=580 $Y=0 $dt=8
M2 2 3 1 1 pfet_01v8 L=3e-07 W=3e-06 $X=1160 $Y=0 $dt=8
M3 1 3 2 1 pfet_01v8 L=3e-07 W=3e-06 $X=1740 $Y=0 $dt=8
.ends pfet_01v8_CDNS_754877090685

* +++++++++++++++++++++++++++++++++++++++++++++++++++++++++ *
* Sub cell: cap_mim_m3__base_CDNS_754877090686              *
* +++++++++++++++++++++++++++++++++++++++++++++++++++++++++ *
.subckt cap_mim_m3__base_CDNS_754877090686 1 2
** N=2 EP=2 FDC=1
C0 2 1 L=4e-06 W=1.1e-05 $[cap_mim_m3__base] $X=0 $Y=0 $dt=10
.ends cap_mim_m3__base_CDNS_754877090686

* +++++++++++++++++++++++++++++++++++++++++++++++++++++++++ *
* Sub cell: pfet_01v8_CDNS_754877090688                     *
* +++++++++++++++++++++++++++++++++++++++++++++++++++++++++ *
.subckt pfet_01v8_CDNS_754877090688 1 3
** N=52 EP=2 FDC=3
M0 1 3 2 2 pfet_01v8 L=3e-07 W=4e-06 $X=0 $Y=0 $dt=8
M1 2 3 1 2 pfet_01v8 L=3e-07 W=4e-06 $X=580 $Y=0 $dt=8
M2 1 3 2 2 pfet_01v8 L=3e-07 W=4e-06 $X=1160 $Y=0 $dt=8
.ends pfet_01v8_CDNS_754877090688

* +++++++++++++++++++++++++++++++++++++++++++++++++++++++++ *
* Sub cell: nfet_01v8_CDNS_754877090689                     *
* +++++++++++++++++++++++++++++++++++++++++++++++++++++++++ *
.subckt nfet_01v8_CDNS_754877090689 1 2 3 4
** N=17 EP=4 FDC=3
M0 1 3 2 4 nfet_01v8 L=3e-07 W=1e-06 $X=0 $Y=0 $dt=7
M1 2 3 1 4 nfet_01v8 L=3e-07 W=1e-06 $X=580 $Y=0 $dt=7
M2 1 3 2 4 nfet_01v8 L=3e-07 W=1e-06 $X=1160 $Y=0 $dt=7
.ends nfet_01v8_CDNS_754877090689

* +++++++++++++++++++++++++++++++++++++++++++++++++++++++++ *
* Sub cell: inverter_nmos3finger_3u                         *
* +++++++++++++++++++++++++++++++++++++++++++++++++++++++++ *
.subckt inverter_nmos3finger_3u 1 2 3 4
** N=5 EP=4 FDC=6
X84 1 2 pfet_01v8_CDNS_754877090688 $T=1185 2810 0 0 $X=740 $Y=2630
X85 1 3 2 4 nfet_01v8_CDNS_754877090689 $T=1185 1780 1 0 $X=780 $Y=0
.ends inverter_nmos3finger_3u

* +++++++++++++++++++++++++++++++++++++++++++++++++++++++++ *
* Sub cell: nfet_01v8_CDNS_7548770906810                    *
* +++++++++++++++++++++++++++++++++++++++++++++++++++++++++ *
.subckt nfet_01v8_CDNS_7548770906810 1 2 3 4
** N=22 EP=4 FDC=1
M0 1 3 2 4 nfet_01v8 L=3e-07 W=3e-06 $X=0 $Y=0 $dt=7
.ends nfet_01v8_CDNS_7548770906810

* +++++++++++++++++++++++++++++++++++++++++++++++++++++++++ *
* Sub cell: res_xhigh_po_0p35_CDNS_7548770906811            *
* +++++++++++++++++++++++++++++++++++++++++++++++++++++++++ *
.subckt res_xhigh_po_0p35_CDNS_7548770906811 1
** N=31 EP=1 FDC=14
R0 2 3 L=6e-06 W=3.5e-07 $[res_xhigh_po_0p35] $SUB=1 $X=0 $Y=-50 $dt=9
R1 2 3 L=6e-06 W=3.5e-07 $[res_xhigh_po_0p35] $SUB=1 $X=720 $Y=-50 $dt=9
R2 2 3 L=6e-06 W=3.5e-07 $[res_xhigh_po_0p35] $SUB=1 $X=1440 $Y=-50 $dt=9
R3 2 3 L=6e-06 W=3.5e-07 $[res_xhigh_po_0p35] $SUB=1 $X=2160 $Y=-50 $dt=9
R4 2 3 L=6e-06 W=3.5e-07 $[res_xhigh_po_0p35] $SUB=1 $X=2880 $Y=-50 $dt=9
R5 2 3 L=6e-06 W=3.5e-07 $[res_xhigh_po_0p35] $SUB=1 $X=3600 $Y=-50 $dt=9
R6 2 3 L=6e-06 W=3.5e-07 $[res_xhigh_po_0p35] $SUB=1 $X=4320 $Y=-50 $dt=9
R7 2 3 L=6e-06 W=3.5e-07 $[res_xhigh_po_0p35] $SUB=1 $X=5040 $Y=-50 $dt=9
R8 2 3 L=6e-06 W=3.5e-07 $[res_xhigh_po_0p35] $SUB=1 $X=5760 $Y=-50 $dt=9
R9 2 3 L=6e-06 W=3.5e-07 $[res_xhigh_po_0p35] $SUB=1 $X=6480 $Y=-50 $dt=9
R10 2 3 L=6e-06 W=3.5e-07 $[res_xhigh_po_0p35] $SUB=1 $X=7200 $Y=-50 $dt=9
R11 2 3 L=6e-06 W=3.5e-07 $[res_xhigh_po_0p35] $SUB=1 $X=7920 $Y=-50 $dt=9
R12 2 3 L=6e-06 W=3.5e-07 $[res_xhigh_po_0p35] $SUB=1 $X=8640 $Y=-50 $dt=9
R13 2 3 L=6e-06 W=3.5e-07 $[res_xhigh_po_0p35] $SUB=1 $X=9360 $Y=-50 $dt=9
.ends res_xhigh_po_0p35_CDNS_7548770906811

* +++++++++++++++++++++++++++++++++++++++++++++++++++++++++ *
* Sub cell: ring_osc                                        *
* +++++++++++++++++++++++++++++++++++++++++++++++++++++++++ *
.subckt ring_osc
** N=22 EP=0 FDC=77
X108 14 15 13 8 inverter_nmos4finger_6_2u $T=255 7945 0 0 $X=255 $Y=7845
X109 16 14 13 8 inverter_nmos4finger_6_2u $T=5375 7945 0 0 $X=5375 $Y=7845
X110 17 16 13 18 inverter_nmos4finger_6_2u $T=10495 7945 0 0 $X=10495 $Y=7845
X111 19 17 13 8 inverter_nmos4finger_6_2u $T=15615 7945 0 0 $X=15615 $Y=7845
X112 20 19 13 8 inverter_nmos4finger_6_2u $T=20735 7945 0 0 $X=20735 $Y=7845
X113 5 9 13 nfet_01v8_CDNS_754877090684 $T=25995 1520 0 0 $X=25590 $Y=740
X114 5 9 pfet_01v8_CDNS_754877090685 $T=25995 3220 0 0 $X=25550 $Y=3040
X115 20 9 cap_mim_m3__base_CDNS_754877090686 $T=13250 3085 0 0 $X=12850 $Y=2685
X116 21 5 2 13 inverter_nmos3finger_3u $T=29340 735 0 0 $X=29340 $Y=735
X117 22 21 2 13 inverter_nmos3finger_3u $T=33215 735 0 0 $X=33215 $Y=735
X118 1 2 10 13 nfet_01v8_CDNS_7548770906810 $T=10735 3895 1 180 $X=10030 $Y=3115
X119 13 2 10 13 nfet_01v8_CDNS_7548770906810 $T=11960 3895 0 0 $X=11555 $Y=3115
X120 13 res_xhigh_po_0p35_CDNS_7548770906811 $T=26315 11900 0 0 $X=26115 $Y=11430
.ends ring_osc

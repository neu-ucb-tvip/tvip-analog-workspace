* +++++++++++++++++++++++++++++++++++++++++++++++++++++++++ *
* CDL Netlist:                                              *
*                                                           *
* Cell Name  : inverter_nmos3finger_3u                      *
* Netlisted  : Mon Aug 18 00:47:50 2025                     *
* Pegasus Version: 22.14-s007 Tue Jan 31 16:35:56 PST 2023  *
* +++++++++++++++++++++++++++++++++++++++++++++++++++++++++ *
*.LDD
*.DEVTMPLT 0 R(res_generic_m1) met1_res met1(P) met1(N)
*.DEVTMPLT 1 R(res_generic_m2) met2_res met2(P) met2(N)
*.DEVTMPLT 2 R(res_generic_m3) met3_res met3(P) met3(N)
*.DEVTMPLT 3 R(res_generic_m4) met4_res met4(P) met4(N)
*.DEVTMPLT 4 R(res_generic_m5) met5_res met5(P) met5(N)
*.DEVTMPLT 5 R(RES_GENERIC_ND) diff_res np_term(P) np_term(N)
*.DEVTMPLT 6 R(RES_GENERIC_PD) diff_res pp_term(P) pp_term(N)
*.DEVTMPLT 7 MN(nfet_01v8) nfet_01v8_rec nSourceDrain(D) nfet(G) nSourceDrain(S) pwell(B)
*.DEVTMPLT 8 MP(pfet_01v8) pfet_01v8_rec pSourceDrain(D) pfet(G) pSourceDrain(S) nwell(B)

* +++++++++++++++++++++++++++++++++++++++++++++++++++++++++ *
* Sub cell: polyConn_CDNS_755502975150                      *
* +++++++++++++++++++++++++++++++++++++++++++++++++++++++++ *
.subckt polyConn_CDNS_755502975150 1 2
** N=6 EP=2 FDC=0
.ends polyConn_CDNS_755502975150

* +++++++++++++++++++++++++++++++++++++++++++++++++++++++++ *
* Sub cell: L1M1_C_CDNS_755502975150                        *
* +++++++++++++++++++++++++++++++++++++++++++++++++++++++++ *
.subckt L1M1_C_CDNS_755502975150 1
** N=1 EP=1 FDC=0
.ends L1M1_C_CDNS_755502975150

* +++++++++++++++++++++++++++++++++++++++++++++++++++++++++ *
* Sub cell: M1M2_C_CDNS_755502975151                        *
* +++++++++++++++++++++++++++++++++++++++++++++++++++++++++ *
.subckt M1M2_C_CDNS_755502975151 1
** N=1 EP=1 FDC=0
.ends M1M2_C_CDNS_755502975151

* +++++++++++++++++++++++++++++++++++++++++++++++++++++++++ *
* Sub cell: M1M2_C_CDNS_755502975152                        *
* +++++++++++++++++++++++++++++++++++++++++++++++++++++++++ *
.subckt M1M2_C_CDNS_755502975152 1
** N=1 EP=1 FDC=0
.ends M1M2_C_CDNS_755502975152

* +++++++++++++++++++++++++++++++++++++++++++++++++++++++++ *
* Sub cell: M1M2_C_CDNS_755502975153                        *
* +++++++++++++++++++++++++++++++++++++++++++++++++++++++++ *
.subckt M1M2_C_CDNS_755502975153 1
** N=1 EP=1 FDC=0
.ends M1M2_C_CDNS_755502975153

* +++++++++++++++++++++++++++++++++++++++++++++++++++++++++ *
* Sub cell: L1M1_C_CDNS_755502975154                        *
* +++++++++++++++++++++++++++++++++++++++++++++++++++++++++ *
.subckt L1M1_C_CDNS_755502975154 1
** N=1 EP=1 FDC=0
.ends L1M1_C_CDNS_755502975154

* +++++++++++++++++++++++++++++++++++++++++++++++++++++++++ *
* Sub cell: L1M1_C_CDNS_755502975155                        *
* +++++++++++++++++++++++++++++++++++++++++++++++++++++++++ *
.subckt L1M1_C_CDNS_755502975155 1
** N=1 EP=1 FDC=0
.ends L1M1_C_CDNS_755502975155

* +++++++++++++++++++++++++++++++++++++++++++++++++++++++++ *
* Sub cell: M1M2_C_CDNS_755502975156                        *
* +++++++++++++++++++++++++++++++++++++++++++++++++++++++++ *
.subckt M1M2_C_CDNS_755502975156 1
** N=1 EP=1 FDC=0
.ends M1M2_C_CDNS_755502975156

* +++++++++++++++++++++++++++++++++++++++++++++++++++++++++ *
* Sub cell: L1M1_C_CDNS_755502975157                        *
* +++++++++++++++++++++++++++++++++++++++++++++++++++++++++ *
.subckt L1M1_C_CDNS_755502975157 1
** N=1 EP=1 FDC=0
.ends L1M1_C_CDNS_755502975157

* +++++++++++++++++++++++++++++++++++++++++++++++++++++++++ *
* Sub cell: M2M3_C_CDNS_755502975159                        *
* +++++++++++++++++++++++++++++++++++++++++++++++++++++++++ *
.subckt M2M3_C_CDNS_755502975159 1
** N=1 EP=1 FDC=0
.ends M2M3_C_CDNS_755502975159

* +++++++++++++++++++++++++++++++++++++++++++++++++++++++++ *
* Sub cell: M1M2_C_CDNS_7555029751510                       *
* +++++++++++++++++++++++++++++++++++++++++++++++++++++++++ *
.subckt M1M2_C_CDNS_7555029751510 1
** N=1 EP=1 FDC=0
.ends M1M2_C_CDNS_7555029751510

* +++++++++++++++++++++++++++++++++++++++++++++++++++++++++ *
* Sub cell: pfet_01v8_CDNS_755502975151                     *
* +++++++++++++++++++++++++++++++++++++++++++++++++++++++++ *
.subckt pfet_01v8_CDNS_755502975151 1 2 3
** N=52 EP=3 FDC=3
M0 1 3 2 2 pfet_01v8 L=3e-07 W=4e-06 $X=0 $Y=0 $dt=8
M1 2 3 1 2 pfet_01v8 L=3e-07 W=4e-06 $X=580 $Y=0 $dt=8
M2 1 3 2 2 pfet_01v8 L=3e-07 W=4e-06 $X=1160 $Y=0 $dt=8
.ends pfet_01v8_CDNS_755502975151

* +++++++++++++++++++++++++++++++++++++++++++++++++++++++++ *
* Sub cell: nfet_01v8_CDNS_755502975152                     *
* +++++++++++++++++++++++++++++++++++++++++++++++++++++++++ *
.subckt nfet_01v8_CDNS_755502975152 1 2 3
** N=16 EP=3 FDC=3
M0 1 3 2 2 nfet_01v8 L=3e-07 W=1e-06 $X=0 $Y=0 $dt=7
M1 2 3 1 2 nfet_01v8 L=3e-07 W=1e-06 $X=580 $Y=0 $dt=7
M2 1 3 2 2 nfet_01v8 L=3e-07 W=1e-06 $X=1160 $Y=0 $dt=7
.ends nfet_01v8_CDNS_755502975152

* +++++++++++++++++++++++++++++++++++++++++++++++++++++++++ *
* Sub cell: inverter_nmos3finger_3u                         *
* +++++++++++++++++++++++++++++++++++++++++++++++++++++++++ *
.subckt inverter_nmos3finger_3u
** N=4 EP=0 FDC=6
X0 1 2 polyConn_CDNS_755502975150 $T=1915 2285 0 0 $X=1190 $Y=2100
X1 2 L1M1_C_CDNS_755502975150 $T=1045 1650 0 0 $X=930 $Y=1465
X2 3 L1M1_C_CDNS_755502975150 $T=1045 2940 0 0 $X=930 $Y=2755
X3 4 L1M1_C_CDNS_755502975150 $T=1615 2875 0 0 $X=1500 $Y=2690
X4 4 L1M1_C_CDNS_755502975150 $T=1625 980 0 0 $X=1510 $Y=795
X5 4 L1M1_C_CDNS_755502975150 $T=1625 1615 0 0 $X=1510 $Y=1430
X6 4 L1M1_C_CDNS_755502975150 $T=1625 3505 0 0 $X=1510 $Y=3320
X7 4 L1M1_C_CDNS_755502975150 $T=1625 4135 0 0 $X=1510 $Y=3950
X8 4 L1M1_C_CDNS_755502975150 $T=1625 4790 0 0 $X=1510 $Y=4605
X9 4 L1M1_C_CDNS_755502975150 $T=1625 5420 0 0 $X=1510 $Y=5235
X10 4 L1M1_C_CDNS_755502975150 $T=1625 6075 0 0 $X=1510 $Y=5890
X11 4 L1M1_C_CDNS_755502975150 $T=1625 6710 0 0 $X=1510 $Y=6525
X12 2 L1M1_C_CDNS_755502975150 $T=2200 1650 0 0 $X=2085 $Y=1465
X13 3 L1M1_C_CDNS_755502975150 $T=2205 2940 0 0 $X=2090 $Y=2755
X14 2 M1M2_C_CDNS_755502975151 $T=1045 285 0 0 $X=885 $Y=125
X15 2 M1M2_C_CDNS_755502975151 $T=2200 285 0 0 $X=2040 $Y=125
X16 3 M1M2_C_CDNS_755502975151 $T=2205 7295 0 0 $X=2045 $Y=7135
X17 4 M1M2_C_CDNS_755502975151 $T=3415 2285 0 0 $X=3255 $Y=2125
X18 2 M1M2_C_CDNS_755502975152 $T=1045 1650 0 0 $X=915 $Y=1465
X19 3 M1M2_C_CDNS_755502975152 $T=1045 2940 0 0 $X=915 $Y=2755
X20 4 M1M2_C_CDNS_755502975152 $T=1615 2875 0 0 $X=1485 $Y=2690
X21 4 M1M2_C_CDNS_755502975152 $T=1625 980 0 0 $X=1495 $Y=795
X22 4 M1M2_C_CDNS_755502975152 $T=1625 1615 0 0 $X=1495 $Y=1430
X23 4 M1M2_C_CDNS_755502975152 $T=1625 3505 0 0 $X=1495 $Y=3320
X24 4 M1M2_C_CDNS_755502975152 $T=1625 4135 0 0 $X=1495 $Y=3950
X25 4 M1M2_C_CDNS_755502975152 $T=1625 4790 0 0 $X=1495 $Y=4605
X26 4 M1M2_C_CDNS_755502975152 $T=1625 5420 0 0 $X=1495 $Y=5235
X27 4 M1M2_C_CDNS_755502975152 $T=1625 6075 0 0 $X=1495 $Y=5890
X28 4 M1M2_C_CDNS_755502975152 $T=1625 6710 0 0 $X=1495 $Y=6525
X29 2 M1M2_C_CDNS_755502975152 $T=2200 1650 0 0 $X=2070 $Y=1465
X30 3 M1M2_C_CDNS_755502975152 $T=2205 2940 0 0 $X=2075 $Y=2755
X31 2 M1M2_C_CDNS_755502975153 $T=1010 980 0 0 $X=925 $Y=785
X32 2 M1M2_C_CDNS_755502975153 $T=2200 980 0 0 $X=2115 $Y=785
X33 2 L1M1_C_CDNS_755502975154 $T=1010 980 0 0 $X=905 $Y=785
X34 2 L1M1_C_CDNS_755502975154 $T=2200 980 0 0 $X=2095 $Y=785
X35 4 L1M1_C_CDNS_755502975155 $T=2775 2875 0 0 $X=2645 $Y=2715
X36 4 L1M1_C_CDNS_755502975155 $T=2785 980 0 0 $X=2655 $Y=820
X37 4 L1M1_C_CDNS_755502975155 $T=2785 1615 0 0 $X=2655 $Y=1455
X38 4 L1M1_C_CDNS_755502975155 $T=2785 3505 0 0 $X=2655 $Y=3345
X39 4 L1M1_C_CDNS_755502975155 $T=2785 4135 0 0 $X=2655 $Y=3975
X40 4 L1M1_C_CDNS_755502975155 $T=2785 4790 0 0 $X=2655 $Y=4630
X41 4 L1M1_C_CDNS_755502975155 $T=2785 5420 0 0 $X=2655 $Y=5260
X42 4 L1M1_C_CDNS_755502975155 $T=2785 6075 0 0 $X=2655 $Y=5915
X43 4 M1M2_C_CDNS_755502975156 $T=2775 2875 0 0 $X=2635 $Y=2690
X44 4 M1M2_C_CDNS_755502975156 $T=2785 980 0 0 $X=2645 $Y=795
X45 4 M1M2_C_CDNS_755502975156 $T=2785 1615 0 0 $X=2645 $Y=1430
X46 4 M1M2_C_CDNS_755502975156 $T=2785 3505 0 0 $X=2645 $Y=3320
X47 4 M1M2_C_CDNS_755502975156 $T=2785 4135 0 0 $X=2645 $Y=3950
X48 4 M1M2_C_CDNS_755502975156 $T=2785 4790 0 0 $X=2645 $Y=4605
X49 4 M1M2_C_CDNS_755502975156 $T=2785 5420 0 0 $X=2645 $Y=5235
X50 4 M1M2_C_CDNS_755502975156 $T=2785 6075 0 0 $X=2645 $Y=5890
X51 3 L1M1_C_CDNS_755502975157 $T=1045 5060 0 0 $X=915 $Y=3320
X52 3 L1M1_C_CDNS_755502975157 $T=2205 5060 0 0 $X=2075 $Y=3320
X53 4 M2M3_C_CDNS_755502975159 $T=1615 2875 0 0 $X=1450 $Y=2690
X54 4 M2M3_C_CDNS_755502975159 $T=1625 980 0 0 $X=1460 $Y=795
X55 4 M2M3_C_CDNS_755502975159 $T=1625 1615 0 0 $X=1460 $Y=1430
X56 4 M2M3_C_CDNS_755502975159 $T=1625 3505 0 0 $X=1460 $Y=3320
X57 4 M2M3_C_CDNS_755502975159 $T=1625 4135 0 0 $X=1460 $Y=3950
X58 4 M2M3_C_CDNS_755502975159 $T=1625 4790 0 0 $X=1460 $Y=4605
X59 4 M2M3_C_CDNS_755502975159 $T=1625 5420 0 0 $X=1460 $Y=5235
X60 4 M2M3_C_CDNS_755502975159 $T=1625 6075 0 0 $X=1460 $Y=5890
X61 4 M2M3_C_CDNS_755502975159 $T=1625 6710 0 0 $X=1460 $Y=6525
X62 4 M2M3_C_CDNS_755502975159 $T=2775 2875 0 0 $X=2610 $Y=2690
X63 4 M2M3_C_CDNS_755502975159 $T=2785 980 0 0 $X=2620 $Y=795
X64 4 M2M3_C_CDNS_755502975159 $T=2785 1615 0 0 $X=2620 $Y=1430
X65 4 M2M3_C_CDNS_755502975159 $T=2785 3505 0 0 $X=2620 $Y=3320
X66 4 M2M3_C_CDNS_755502975159 $T=2785 4135 0 0 $X=2620 $Y=3950
X67 4 M2M3_C_CDNS_755502975159 $T=2785 4790 0 0 $X=2620 $Y=4605
X68 4 M2M3_C_CDNS_755502975159 $T=2785 5420 0 0 $X=2620 $Y=5235
X69 4 M2M3_C_CDNS_755502975159 $T=2785 6075 0 0 $X=2620 $Y=5890
X70 4 M2M3_C_CDNS_755502975159 $T=3415 980 0 0 $X=3250 $Y=795
X71 4 M2M3_C_CDNS_755502975159 $T=3415 1625 0 0 $X=3250 $Y=1440
X72 4 M2M3_C_CDNS_755502975159 $T=3415 2875 0 0 $X=3250 $Y=2690
X73 4 M2M3_C_CDNS_755502975159 $T=3415 3505 0 0 $X=3250 $Y=3320
X74 4 M2M3_C_CDNS_755502975159 $T=3415 4135 0 0 $X=3250 $Y=3950
X75 4 M2M3_C_CDNS_755502975159 $T=3415 4790 0 0 $X=3250 $Y=4605
X76 4 M2M3_C_CDNS_755502975159 $T=3415 5420 0 0 $X=3250 $Y=5235
X77 4 M2M3_C_CDNS_755502975159 $T=3415 6075 0 0 $X=3250 $Y=5890
X78 4 M2M3_C_CDNS_755502975159 $T=3415 6710 0 0 $X=3250 $Y=6525
X79 3 M1M2_C_CDNS_7555029751510 $T=1045 5060 0 0 $X=915 $Y=3320
X80 3 M1M2_C_CDNS_7555029751510 $T=2205 5060 0 0 $X=2075 $Y=3320
X81 4 3 1 pfet_01v8_CDNS_755502975151 $T=1185 2810 0 0 $X=740 $Y=2630
X82 4 2 1 nfet_01v8_CDNS_755502975152 $T=1185 1780 1 0 $X=780 $Y=0
.ends inverter_nmos3finger_3u
